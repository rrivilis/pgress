* rtl/spice/t_zero.spice
*
* T_ZERO — frustration isolation cell
*
* Semantics:
*   A T_DFF variant that, once its output reaches the Zero state {p1=1, p0=0},
*   internally locks out the clock enable. All further input changes are
*   ignored (CE_eff = 0) until an explicit synchronous reset.
*
*   This models the "frustrated/conflicted logic state" in pgress: once a
*   region node reaches Zero (Bochvar contradiction), it has no further
*   computation to do. It stays Zero until the dependency graph is reset.
*
* Why T_ZERO vs T_DFF at Zero:
*   A plain T_DFF at Zero still runs the CE comparison every clock cycle
*   (comb_out is evaluated → XOR comparator sees comb_out==out → ce=0, but
*   the XOR comparator itself switches briefly on each clock edge as the
*   upstream combinational logic ripples). T_ZERO adds an internal CE lockout
*   that short-circuits CE to 0 without consulting the comparator:
*
*     is_at_zero  = out[1] &  ~out[0]   (p1=1 AND p0=0)
*     CE_eff      = CE_ext & ~is_at_zero
*
*   Once out == Zero: CE_eff = 0. The MUX never updates D_eff. The XOR
*   comparator is still live, but the DFF input is frozen.
*
* Implementation (sky130):
*   T_DFF core (2 bits):
*     Xinv_rst, Xmux_p0, Xdff_p0, Xmux_p1, Xdff_p1 (same as t_dff.spice)
*   Lockout logic:
*     Xinv_q0    : inv_1 (Q_p0 → inv_q0)
*     Xdetect    : and2_0 (Q_p1, inv_q0 → is_at_zero)  detect out==Zero
*     Xlockout   : nand2_1 (CE_ext, is_at_zero → ce_gate_b)
*     Xinv_ce    : inv_1 (ce_gate_b → CE_eff)
*   Total: 5 (DFF core) + 4 (lockout) = 9 cells, ~40 transistors
*
* Measurements (three phases):
*
*   Phase 1 (0–40 ns): Active — cell toggling between Neg and Pos at 250 MHz.
*     power_active: baseline dynamic power while CE=1 and output changes.
*
*   Phase 2 (40–44 ns): Zero arrives — a single Zero input is presented.
*     The cell latches Zero on the next clock edge (one final switching event).
*     After that clock edge: is_at_zero=1 → CE_eff=0 → lockout engaged.
*     power_transition: energy of the final Zero-latching edge.
*
*   Phase 3 (44–120 ns): Frustrated/isolated — output locked at Zero.
*     CE_ext=1 (still driven high externally), D changes (Zero input persists),
*     but CE_eff=0 because of the lockout. DFF draws only leakage.
*     power_isolated: leakage current during frustration isolation.
*
* Key result: The current waveform shows a step-function:
*   [active ripple] → [single transient peak at Zero latch] → [flat leakage]
*
* This is the transistor-level proof that frustration isolation is structural,
* not runtime: once Zero is detected, dynamic power drops to leakage floor
* without any software-level intervention.
*
* Frustration isolation factor = power_active / power_isolated
* Expected: 10–100x at sky130 130nm; higher at smaller nodes.

.title T_ZERO frustration isolation cell — sky130_fd_sc_hd

.include "$PDK_ROOT/sky130_fd_sc_hd.spice"

.param VDD=1.8
Vvdd VDD 0 DC 'VDD'
Vvss VSS 0 DC 0

* ── DUT: T_DFF core ──────────────────────────────────────────────────────────
* sky130_fd_sc_hd pin order:
*   inv_1:   A VGND VNB VPB VPWR Y
*   mux2_1:  A0 A1 S VGND VNB VPB VPWR X   (S=0→A0, S=1→A1)
*   dfrtp_1: CLK D RESET_B VGND VNB VPB VPWR Q
*   and2_0:  A B VGND VNB VPB VPWR X
*   nand2_1: A B VGND VNB VPB VPWR Y
* VNB=VSS (N-well body), VPB=VDD (P-well body)

Xinv_rst RST VSS VSS VDD VDD RST_B  sky130_fd_sc_hd__inv_1

* mux: S=CE_eff=0 → hold Q (A0); S=CE_eff=1 → load D (A1)
Xmux_p0  Q_p0 D_p0 CE_eff  VSS VSS VDD VDD D_eff_p0  sky130_fd_sc_hd__mux2_1
Xdff_p0  CLK D_eff_p0 RST_B  VSS VSS VDD VDD Q_p0    sky130_fd_sc_hd__dfrtp_1

Xmux_p1  Q_p1 D_p1 CE_eff  VSS VSS VDD VDD D_eff_p1  sky130_fd_sc_hd__mux2_1
Xdff_p1  CLK D_eff_p1 RST_B  VSS VSS VDD VDD Q_p1    sky130_fd_sc_hd__dfrtp_1

* ── DUT: CE lockout (frustration isolation) ──────────────────────────────────
* Detect Zero state: is_at_zero = Q_p1 & ~Q_p0
Xinv_q0  Q_p0 VSS VSS VDD VDD inv_q0  sky130_fd_sc_hd__inv_1
Xdetect  Q_p1 inv_q0 VSS VSS VDD VDD is_at_zero  sky130_fd_sc_hd__and2_0

* CE_eff = CE_ext & ~is_at_zero
* Implement as: NAND2(CE_ext, is_at_zero) → INV → CE_eff
Xlockout  CE_ext is_at_zero VSS VSS VDD VDD ce_gate_b  sky130_fd_sc_hd__nand2_1
Xinv_ce   ce_gate_b VSS VSS VDD VDD CE_eff              sky130_fd_sc_hd__inv_1

* ── Parameters ───────────────────────────────────────────────────────────────
.param TCLK=4ns
.param TRESET=2ns

* ── Clock (250 MHz) ──────────────────────────────────────────────────────────
VCLK CLK 0 PULSE(0 'VDD' 0 10ps 10ps '(TCLK/2)-10ps' 'TCLK')

* ── Reset: assert for first 2 ns ─────────────────────────────────────────────
VRST RST 0 PWL(0 'VDD'  'TRESET' 'VDD'  'TRESET+0.01ns' 0  200ns 0)

* ── CE_ext: external clock enable (held 1 throughout — lockout is internal) ──
VCE CE_ext 0 DC 'VDD'

* ── Stimulus ─────────────────────────────────────────────────────────────────
* Phase 1 (2–40 ns): Neg ↔ Pos toggling
*   D = Neg {p0=0,p1=0} or Pos {p0=1,p1=0}, alternating each cycle.
*   p1 stays 0 throughout phase 1; p0 toggles.

VD_p0 D_p0 0 PWL(
+  0        0
+  2ns      0
+  2.01ns   0
*  Pos phase: p0=1 from t=2ns to 40ns, toggling each clock
+  5.8ns   'VDD'
+  7.8ns    0
+  9.8ns   'VDD'
+ 11.8ns    0
+ 13.8ns   'VDD'
+ 15.8ns    0
+ 17.8ns   'VDD'
+ 19.8ns    0
+ 21.8ns   'VDD'
+ 23.8ns    0
+ 25.8ns   'VDD'
+ 27.8ns    0
+ 29.8ns   'VDD'
+ 31.8ns    0
+ 33.8ns   'VDD'
+ 35.8ns    0
+ 37.8ns   'VDD'
+ 39.8ns    0
*  Phase 2: Zero arrives at t=40ns — D_p0 goes 0, D_p1 goes 1
+ 40ns      0
+ 120ns     0)

VD_p1 D_p1 0 PWL(
+  0       0
+ 40ns     0
* Phase 2 at t=40ns: Zero = {p0=0, p1=1}
+ 40.01ns 'VDD'
+ 120ns   'VDD')

* ── Simulation ───────────────────────────────────────────────────────────────
.tran 1ps 120ns

* ── Measurements ─────────────────────────────────────────────────────────────
* Phase 1: active power (Neg/Pos toggling, 250 MHz)
.measure tran power_active AVG par('(-v(VDD)*i(Vvdd))') FROM=2ns TO=40ns

* Phase 2: transition energy (single Zero-latch clock edge)
* Zero arrives at t=40ns; the next posedge is at t=42ns (assuming clk starts at 0).
* Measure over 2 clock cycles around the transition.
.measure tran power_transition AVG par('(-v(VDD)*i(Vvdd))') FROM=40ns TO=48ns

* Phase 3: isolated / frustrated (locked at Zero, leakage only)
* By t=48ns, is_at_zero=1 and CE_eff=0. Measure steady-state leakage.
.measure tran power_isolated AVG par('(-v(VDD)*i(Vvdd))') FROM=60ns TO=120ns

* Verify lockout: CE_eff must be 0 during phase 3
.measure tran ce_eff_during_isolation AVG v(CE_eff) FROM=60ns TO=120ns

* ── Output ───────────────────────────────────────────────────────────────────
.print tran v(CLK) v(D_p0) v(D_p1) v(Q_p0) v(Q_p1) v(is_at_zero) v(CE_eff)
.control
  run
  plot v(CLK)+4 v(D_p0)+3 v(D_p1)+2 v(Q_p0)+1 v(is_at_zero) v(CE_eff)
  echo "--- T_ZERO power characterization ---"
  print power_active power_transition power_isolated
  echo "--- Frustration isolation factor (active/isolated):"
  let isolation_factor = power_active / power_isolated
  print isolation_factor
  echo "--- CE_eff avg during isolation (should be ~0):"
  print ce_eff_during_isolation
.endc

.end
